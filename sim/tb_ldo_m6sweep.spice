* tb_ldo_m6sweep -- DIAGNOSTIC. Tests the intervention that tb_ldo_slewtest's result points
* at: the load-release cliff is a dI/dt threshold, so it should move with the current that
* sets how fast eout can rise, and with nothing else.
*
* XM6 in ldo_erramp is the ONLY pull-up on eout -- a w=2u/l=1u pMOS mirroring roughly 5 uA
* out of the ~10 uA reference set by XMp0 (w=4u). This bench runs against a netlist whose
* XM6 width has been substituted, so each width is a real elaborated device rather than an
* `alter` that may or may not have landed.
*
* ⛔ WHY NOT `alter`. The first attempt used `alter @m.x_amp.xm6.msg13_hv_pmos w=8u`, which
* ngspice rejected -- "no such device or model name" -- and then CARRIED ON, running the
* unmodified circuit and reporting it as the fixed one. It was caught only because the
* quiescent current came back at 3.580622e-05, bit-for-bit the unmodified value. A bench
* that cannot tell a failed modification from a successful one proves nothing, so the
* width is substituted in the netlist and the substitution is checked before the run.
*
* Expected if the dI/dt account is right, and these are the predictions to judge it by:
*   - overshoot at 1 -> 7 mA / 1 us (6 mA/us, above the 5.0-5.5 mA/us threshold) stops
*     railing once XM6 is wide enough to lift that threshold past 6 mA/us
*   - the threshold moves ROUGHLY IN PROPORTION to the width, since it is I/C on a fixed C
*   - the DROOP is barely affected: it is set by how fast eout falls, which is XM5's
*     transconductance, not XM6's current
*   - quiescent current rises by the added pull-up, directly and measurably
*
* The last is the constraint that decides how far this can go: the block publishes 35.8 uA
* against a 60 uA budget.
*
* Run: cd sim && ngspice -b tb_ldo_m6sweep.spice   (with netlist/ldo_capless_m6var.spice
* generated by sim/m6sweep.sh, which is what sets the width)
.lib $PDK_ROOT/ihp-sg13cmos5l/libs.tech/ngspice/models/cornerMOShv.lib mos_tt
.lib $PDK_ROOT/ihp-sg13cmos5l/libs.tech/ngspice/models/cornerMOSlv.lib mos_tt
.include $PDK_ROOT/ihp-sg13cmos5l/libs.tech/ngspice/models/cap_cmomf.lib
.lib $PDK_ROOT/ihp-sg13cmos5l/libs.tech/ngspice/models/cornerRES.lib res_typ
.include $PDK_ROOT/ihp-sg13cmos5l/libs.ref/sg13cmos5l_stdcell/spice/sg13cmos5l_stdcell.spice
.global sub!
.include ../sim/netlist/ldo_capless_m6var.spice

Vin     vin     0 DC 3.3 AC 1
Vrefbg  vref_bg 0 1.2
Vss     vss     0 0
Vsub    sub!    0 0
Vddd    vddd    0 1.2
Ven     en      0 1.2
Vilim   ilim_en 0 0
Ibias   0       ibias DC 1u
Iload   vout    0 PULSE(1m 7m 20u 1u 1u 20u 60u)
Vt0 vtrim0 0 0
Vt1 vtrim1 0 0
Vt2 vtrim2 0 0
Vt3 vtrim3 0 0
Vt4 vtrim4 0 1.2

.control
  * ---- quiescent current: the budget this intervention spends against
  alter @Iload[pulse] = [ 0 0 20u 1u 1u 20u 60u ]
  op
  let iq = -i(Vin)
  print iq
  print v(vout)
  print v(eout)

  * ---- the failing case
  alter @Iload[pulse] = [ 1m 7m 20u 1u 1u 20u 60u ]
  tran 5n 60u
  meas tran vpre7 FIND v(vout) AT=19u
  meas tran ov7   MAX  v(vout) FROM=41u TO=52u
  meas tran vd7   MIN  v(vout) FROM=20u TO=30u

  * ---- and further up, to find where the new threshold sits
  alter @Iload[pulse] = [ 1m 10m 20u 1u 1u 20u 60u ]
  tran 5n 60u
  meas tran ov10 MAX v(vout) FROM=41u TO=52u
  meas tran vd10 MIN v(vout) FROM=20u TO=30u

  alter @Iload[pulse] = [ 1m 14m 20u 1u 1u 20u 60u ]
  tran 5n 60u
  meas tran ov14 MAX v(vout) FROM=41u TO=52u
  meas tran vd14 MIN v(vout) FROM=20u TO=30u

  * ---- the specification step the datasheet fails on today
  alter @Iload[pulse] = [ 1m 20m 20u 1u 1u 20u 60u ]
  tran 5n 60u
  meas tran ov20 MAX v(vout) FROM=41u TO=52u
  meas tran vd20 MIN v(vout) FROM=20u TO=30u

  * ---- PSRR, the block's other miss. Reported here because the same node is involved,
  * NOT because an effect is predicted: XM6 is the second stage's load, so its current
  * sets that stage's output impedance and gain. Whether that moves 1 kHz rejection is a
  * question this bench answers rather than assumes.
  alter @Iload[pulse] = [ 1m 1m 20u 1u 1u 20u 60u ]
  ac dec 20 10 100meg
  let psrr_db = db(v(vout))
  meas ac psrr_1k  FIND psrr_db AT=1k
  meas ac psrr_10k FIND psrr_db AT=10k
.endc
.end
