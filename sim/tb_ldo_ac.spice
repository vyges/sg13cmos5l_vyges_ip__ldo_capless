* tb_ldo_ac -- open-loop gain and phase of the capless LDO regulation loop.
*
* Capless stability is the design's stated primary risk: with no external output
* capacitor, phase margin has to come from internal compensation, and it is the one
* thing that cannot be measured on silicon at all (there is no loop-break pin), so it
* must be established in simulation.
*
* The loop is broken at the feedback node by a series source, DC 0 / AC 1 (Vinj below):
* a short at DC, so the operating point is the real closed-loop one, and a 1 V injection
* at AC. (This comment described an inductor for several revisions; the netlist has always
* used the source, which is the same idea with one fewer component.)
*   T(f) = -v(vfbd)/v(vfb)      phase margin = 180 + arg(T) where |T| = 1
.lib $PDK_ROOT/ihp-sg13cmos5l/libs.tech/ngspice/models/cornerMOShv.lib mos_tt
.lib $PDK_ROOT/ihp-sg13cmos5l/libs.tech/ngspice/models/cornerMOSlv.lib mos_tt
.include $PDK_ROOT/ihp-sg13cmos5l/libs.tech/ngspice/models/cap_cmomf.lib
.lib $PDK_ROOT/ihp-sg13cmos5l/libs.tech/ngspice/models/cornerRES.lib res_typ
* The resistor model's body terminal is the global substrate node `sub!`. Unless it is
* declared global AND tied, it floats inside each subcircuit, the matrix is singular, and
* ngspice quietly abandons its DC strategies and falls back to a transient operating
* point -- which returns numbers that look plausible and are not solutions. Declare and
* tie it in every bench.
* ldo_enable instantiates a standard-cell inverter for the 1.2 V control-bus side.
.include $PDK_ROOT/ihp-sg13cmos5l/libs.ref/sg13cmos5l_stdcell/spice/sg13cmos5l_stdcell.spice
.global sub!
.include ldo_cells.spice

Vin    vin     0 3.3
Vrefbg vref_bg 0 1.2
Vss    vss     0 0
Vddd   vddd    0 1.2
Ven    en      0 1.2
Vilim  ilim_en 0 1.2
Vsub sub! 0 0
Ibias  0       ibias DC 1u   $ harness supplies 1 uA (ibias1u_*); multiplied 10x on-slot
Iload  vout    0 DC 1m

Vt0 vtrim0 0 0
Vt1 vtrim1 0 0
Vt2 vtrim2 0 0
Vt3 vtrim3 0 0
Vt4 vtrim4 0 1.2

* Blocks instantiated by hand so the feedback node can be broken. Port order MUST track
* the cells -- this bench silently stopped elaborating when ldo_vref, ldo_erramp and
* ldo_enable gained ports, and ngspice then reported "too few parameters" and produced no
* output at all, leaving stale CSVs on disk to be read as if they were results.
x_vref vref_bg vref vss vref_pg ldo_vref
x_amp  vref vfb ibias en_n eout vin vss ldo_erramp
x_pass eout vout vin ldo_pass
x_fb   vtrim0 vtrim1 vtrim2 vtrim3 vtrim4 vfbd vout vss ldo_fbtrim
x_en   en ibias eout en_n vin vddd vss ldo_enable
x_pg   vfb vref_pg ibias pgood vddd vss ldo_pgood
x_il   ibias ilim_en vout eout oc vin vddd vss ldo_ilim

* Loop break. A DC-0 / AC-1 source alone is the whole mechanism: a short at DC, so the
* operating point is the real closed-loop one, and a 1 V injection at AC. An earlier
* revision also placed a 1 TH inductor across it, which adds nothing and puts two
* zero-impedance elements on the same node pair -- a degenerate loop for the DC solve.
Vinj vfbd vfb DC 0 AC 1

* Cc, Cout and the preload are at the top level, not inside any sub-block -- this bench
* instantiates the blocks by hand to get at the feedback node, so it carries them too.
XMpre vout ibias vss vss sg13_hv_nmos w=20u l=1u ng=1 m=1
XCc   eout vout cap_cmomf w=40u l=40u mmin=1 mmax=4
XCout vout vss  cap_cmomf w=125u l=125u mmin=1 mmax=4

* Phase margin is load-dependent in an LDO -- the pass device's gm, and with it the
* output pole, move with load current. A single-load number says very little, so the
* sweep covers no-load to full-load.
* Phase margin is load-dependent in an LDO: the pass device's gm, and with it the
* output pole, moves with load current. A single-load figure says very little, so the
* sweep runs no-load to full-load. (Each load is written explicitly -- ngspice does not
* interpolate a foreach variable into a wrdata path.) Paths are RELATIVE: the runner and
* report.py both chdir into sim/, and an absolute /work/... path only resolved when the
* repository itself was the mount point -- it wrote nothing under the documented
* invocation, so the AC bench silently produced no data at all.
* Phase margin is load-dependent: the pass device's gm, and with it the output pole,
* moves with load current. At very light load the device is barely conducting and the
* loop gain falls away entirely, so the sweep runs from no-load upward to find where the
* loop stops holding -- that minimum is a specification number, not an incidental.
* (Each load is written explicitly; ngspice does not interpolate a foreach variable into
* a wrdata path.)
.control
  alter Iload dc = 0
  op
  ac dec 40 1 1G
  let T000u   = -v(vfbd)/v(vfb)
  let tdb000u = db(T000u)
  let tph000u = 180/pi*cph(T000u)
  wrdata loop_000u.csv tdb000u tph000u
  alter Iload dc = 10u
  op
  ac dec 40 1 1G
  let T010u   = -v(vfbd)/v(vfb)
  let tdb010u = db(T010u)
  let tph010u = 180/pi*cph(T010u)
  wrdata loop_010u.csv tdb010u tph010u
  alter Iload dc = 30u
  op
  ac dec 40 1 1G
  let T030u   = -v(vfbd)/v(vfb)
  let tdb030u = db(T030u)
  let tph030u = 180/pi*cph(T030u)
  wrdata loop_030u.csv tdb030u tph030u
  alter Iload dc = 100u
  op
  ac dec 40 1 1G
  let T100u   = -v(vfbd)/v(vfb)
  let tdb100u = db(T100u)
  let tph100u = 180/pi*cph(T100u)
  wrdata loop_100u.csv tdb100u tph100u
  alter Iload dc = 300u
  op
  ac dec 40 1 1G
  let T300u   = -v(vfbd)/v(vfb)
  let tdb300u = db(T300u)
  let tph300u = 180/pi*cph(T300u)
  wrdata loop_300u.csv tdb300u tph300u
  alter Iload dc = 1m
  op
  ac dec 40 1 1G
  let T001m   = -v(vfbd)/v(vfb)
  let tdb001m = db(T001m)
  let tph001m = 180/pi*cph(T001m)
  wrdata loop_001m.csv tdb001m tph001m
  alter Iload dc = 10m
  op
  ac dec 40 1 1G
  let T010m   = -v(vfbd)/v(vfb)
  let tdb010m = db(T010m)
  let tph010m = 180/pi*cph(T010m)
  wrdata loop_010m.csv tdb010m tph010m
  alter Iload dc = 50m
  op
  ac dec 40 1 1G
  let T050m   = -v(vfbd)/v(vfb)
  let tdb050m = db(T050m)
  let tph050m = 180/pi*cph(T050m)
  wrdata loop_050m.csv tdb050m tph050m
.endc
.end
