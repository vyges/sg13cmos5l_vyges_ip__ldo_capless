* tb_ldo_ilim_lowvin -- REGRESSION TEST for the current-sense cascode.
*
* At the rated 50 mA load, sweeping the supply down must NOT trip the limiter: the pass
* device has not run out, and a protection circuit that fires early truncates the operating
* range the block is specified for. Before the cascode this excursion tripped, which showed
* up as a dropout reading of 730 mV against the 460 mV the pass device actually achieves.
*
* Originally derived from tb_ldo_status -- power-good and current-limit behaviour.
*
* PGOOD should assert while the output is in regulation and deassert when it is not.
* OC should assert once the pass current exceeds the limit, and the limiter should THROTTLE
* the output rather than merely reporting -- so vout must fold back, not keep rising with
* the load.
.lib $PDK_ROOT/ihp-sg13cmos5l/libs.tech/ngspice/models/cornerMOShv.lib mos_tt
.lib $PDK_ROOT/ihp-sg13cmos5l/libs.tech/ngspice/models/cornerMOSlv.lib mos_tt
.include $PDK_ROOT/ihp-sg13cmos5l/libs.tech/ngspice/models/cap_cmomf.lib
.lib $PDK_ROOT/ihp-sg13cmos5l/libs.tech/ngspice/models/cornerRES.lib res_typ
.include $PDK_ROOT/ihp-sg13cmos5l/libs.ref/sg13cmos5l_stdcell/spice/sg13cmos5l_stdcell.spice
.global sub!
.include ../sim/netlist/ldo_capless.spice

Vin     vin     0 3.3
Vrefbg  vref_bg 0 1.2
Vss     vss     0 0
Vsub    sub!    0 0
Vddd    vddd    0 1.2
Ven     en      0 1.2
Vilim   ilim_en 0 1.2
Ibias   0       ibias DC 1u   $ harness supplies 1 uA (ibias1u_*); multiplied 10x on-slot
Iload   vout    0 DC 50m
Vt0 vtrim0 0 0
Vt1 vtrim1 0 0
Vt2 vtrim2 0 0
Vt3 vtrim3 0 0
Vt4 vtrim4 0 1.2

* Named values, not a bare print: the reporting script can only require what has a name.
.control
  alter Iload dc = 50m
  alter Vin dc = 3.3
  op
  echo "VIN=3.3"
  let vo_33 = v(vout)
  let oc_33 = v(oc)
  print vo_33
  print oc_33
  alter Vin dc = 3.0
  op
  echo "VIN=3.0"
  let vo_30 = v(vout)
  let oc_30 = v(oc)
  print vo_30
  print oc_30
  alter Vin dc = 2.6
  op
  echo "VIN=2.6"
  let vo_26 = v(vout)
  let oc_26 = v(oc)
  print vo_26
  print oc_26
  alter Vin dc = 2.2
  op
  echo "VIN=2.2"
  let vo_22 = v(vout)
  let oc_22 = v(oc)
  print vo_22
  print oc_22
  alter Vin dc = 2.0
  op
  echo "VIN=2.0"
  let vo_20 = v(vout)
  let oc_20 = v(oc)
  print vo_20
  print oc_20
.endc
.end
