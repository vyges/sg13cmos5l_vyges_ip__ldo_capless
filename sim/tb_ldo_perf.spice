* tb_ldo_perf -- the specification lines that DC, AC-loop, trim and PVT do not cover:
* dropout, quiescent current, load transient and PSRR.
.lib $PDK_ROOT/ihp-sg13cmos5l/libs.tech/ngspice/models/cornerMOShv.lib mos_tt
.lib $PDK_ROOT/ihp-sg13cmos5l/libs.tech/ngspice/models/cornerMOSlv.lib mos_tt
.include $PDK_ROOT/ihp-sg13cmos5l/libs.tech/ngspice/models/cap_cmomf.lib
.lib $PDK_ROOT/ihp-sg13cmos5l/libs.tech/ngspice/models/cornerRES.lib res_typ
.include $PDK_ROOT/ihp-sg13cmos5l/libs.ref/sg13cmos5l_stdcell/spice/sg13cmos5l_stdcell.spice
.global sub!
.include ../sim/netlist/ldo_capless.spice

Vin     vin     0 DC 3.3 AC 1
Vrefbg  vref_bg 0 1.2
Vss     vss     0 0
Vsub    sub!    0 0
Vddd    vddd    0 1.2
Ven     en      0 1.2
* Limiter OFF for this bench. Dropout characterises the PASS DEVICE -- how far the input
* can fall before the loop loses regulation. With the protection active the sweep measures
* where the limiter fires instead, which is a different quantity, and the two loops fighting
* near the trip point also stops the continuation sweep converging. The limiter's own
* behaviour is measured in tb_ldo_status and tb_ldo_ilim_lowvin.
Vilim   ilim_en 0 0
Ibias   0       ibias DC 1u   $ harness supplies 1 uA (ibias1u_*); multiplied 10x on-slot
* load: DC for the static measurements, PULSE for the transient
Iload   vout    0 PULSE(1m 20m 20u 1u 1u 20u 60u)
Vt0 vtrim0 0 0
Vt1 vtrim1 0 0
Vt2 vtrim2 0 0
Vt3 vtrim3 0 0
Vt4 vtrim4 0 1.2

.control
  * ---- quiescent current: no load, enabled. Subtract nothing -- Iload is zero here,
  * so the whole VIN current is the block's own.
  alter @Iload[pulse] = [ 0 0 20u 1u 1u 20u 60u ]
  op
  let iq = -i(Vin)
  print iq
  print v(vout)

  * ---- dropout at 50 mA: reduce VIN until the output falls 1% below its 3.3 V value
  alter @Iload[pulse] = [ 50m 50m 20u 1u 1u 20u 60u ]
  dc Vin 3.3 1.2 -0.01
  meas dc vo_at33 FIND v(vout) AT=3.3
  * the 1%-droop crossing, referred to the 3.3 V value
  meas dc vin_dr WHEN v(vout)=1.19700
  print vin_dr

  * ---- PSRR: ripple on VIN, measured at the output
  alter @Iload[pulse] = [ 1m 1m 20u 1u 1u 20u 60u ]
  ac dec 20 10 100meg
  let psrr_db = db(v(vout))
  meas ac psrr_1k   FIND psrr_db AT=1k
  meas ac psrr_10k  FIND psrr_db AT=10k
  meas ac psrr_100k FIND psrr_db AT=100k
  meas ac psrr_1m   FIND psrr_db AT=1meg
  * The four .meas points above are the published specification points; this writes the
  * whole sweep so the datasheet can DRAW the curve instead of four dots. Relative path:
  * the runner invokes ngspice with sim/ as the working directory, and an absolute one
  * silently wrote nothing under our own documented invocation once already.
  wrdata psrr.csv psrr_db

  * ---- load transient: 1 -> 20 mA with a 1 us edge, as the specification states
  alter @Iload[pulse] = [ 1m 20m 20u 1u 1u 20u 60u ]
  tran 20n 60u
  meas tran vo_pre    FIND v(vout) AT=19u
  meas tran vo_droop  MIN  v(vout) FROM=20u TO=30u
  meas tran vo_over   MAX  v(vout) FROM=40u TO=50u
  meas tran vo_settle FIND v(vout) AT=39u
  * Write the waveform. The droop and the release overshoot are this block's two headline
  * misses and both are shapes, not scalars -- 338 mV of droop says nothing about how long
  * the output is out of regulation, and "to the 3.3 V rail" says nothing about how sharp
  * the excursion is. A reader scoping the block needs to see them.
  wrdata step.csv v(vout)
.endc
.end
