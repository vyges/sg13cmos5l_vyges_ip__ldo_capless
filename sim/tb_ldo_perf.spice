* tb_ldo_perf -- the specification lines that DC, AC-loop, trim and PVT do not cover:
* dropout, quiescent current, load transient and PSRR.
.lib $PDK_ROOT/ihp-sg13cmos5l/libs.tech/ngspice/models/cornerMOShv.lib mos_tt
.lib $PDK_ROOT/ihp-sg13cmos5l/libs.tech/ngspice/models/cornerMOSlv.lib mos_tt
.include $PDK_ROOT/ihp-sg13cmos5l/libs.tech/ngspice/models/cap_cmomf.lib
.lib $PDK_ROOT/ihp-sg13cmos5l/libs.tech/ngspice/models/cornerRES.lib res_typ
.include $PDK_ROOT/ihp-sg13cmos5l/libs.ref/sg13cmos5l_stdcell/spice/sg13cmos5l_stdcell.spice
.global sub!
.include ../sim/netlist/ldo_capless.spice

Vin     vin     0 DC 3.3 AC 1
Vrefbg  vref_bg 0 1.2
Vss     vss     0 0
Vsub    sub!    0 0
Vddd    vddd    0 1.2
Ven     en      0 1.2
* Limiter OFF for this bench. Dropout characterises the PASS DEVICE -- how far the input
* can fall before the loop loses regulation. With the protection active the sweep measures
* where the limiter fires instead, which is a different quantity, and the two loops fighting
* near the trip point also stops the continuation sweep converging. The limiter's own
* behaviour is measured in tb_ldo_status and tb_ldo_ilim_lowvin.
Vilim   ilim_en 0 0
Ibias   0       ibias DC 1u   $ harness supplies 1 uA (ibias1u_*); multiplied 10x on-slot
* load: DC for the static measurements, PULSE for the transient
Iload   vout    0 PULSE(1m 20m 20u 1u 1u 20u 60u)
Vt0 vtrim0 0 0
Vt1 vtrim1 0 0
Vt2 vtrim2 0 0
Vt3 vtrim3 0 0
Vt4 vtrim4 0 1.2

.control
  * ---- quiescent current: no load, enabled. Subtract nothing -- Iload is zero here,
  * so the whole VIN current is the block's own.
  alter @Iload[pulse] = [ 0 0 20u 1u 1u 20u 60u ]
  op
  let iq = -i(Vin)
  print iq
  print v(vout)

  * ---- dropout at 50 mA: reduce VIN until the output falls 1% below its 3.3 V value
  alter @Iload[pulse] = [ 50m 50m 20u 1u 1u 20u 60u ]
  dc Vin 3.3 1.2 -0.01
  meas dc vo_at33 FIND v(vout) AT=3.3
  * the 1%-droop crossing, referred to the 3.3 V value
  meas dc vin_dr WHEN v(vout)=1.19700
  print vin_dr

  * ---- PSRR: ripple on VIN, measured at the output
  alter @Iload[pulse] = [ 1m 1m 20u 1u 1u 20u 60u ]
  ac dec 20 10 100meg
  let psrr_db = db(v(vout))
  meas ac psrr_100  FIND psrr_db AT=100
  meas ac psrr_1k   FIND psrr_db AT=1k
  meas ac psrr_10k  FIND psrr_db AT=10k
  meas ac psrr_100k FIND psrr_db AT=100k
  meas ac psrr_1m   FIND psrr_db AT=1meg
  * 🔑 Where rejection runs out. The specification is a mask over 100 Hz - 10 kHz and it has
  * to say where it stops being true: above this frequency the block does not reject the
  * supply at all, and around 2 MHz it AMPLIFIES it. rej crosses zero going down, so this is
  * the FALL crossing of -psrr_db.
  let rej = -psrr_db
  meas ac psrr_f0db WHEN rej=0 FALL=1
  * ⚠️ The .meas points above are NOT all specification points. The specification is a mask
  * at 100 Hz, 1 kHz and 10 kHz; 100 kHz and 1 MHz are reported without limits because the
  * block has no rejection there at all. This writes the whole sweep so the datasheet can
  * DRAW the curve instead of a few dots. Relative path:
  * the runner invokes ngspice with sim/ as the working directory, and an absolute one
  * silently wrote nothing under our own documented invocation once already.
  wrdata psrr.csv psrr_db

  * ---- load transient: 1 -> 20 mA with a 1 us edge, as the specification states
  alter @Iload[pulse] = [ 1m 20m 20u 1u 1u 20u 60u ]
  tran 20n 60u
  meas tran vo_pre    FIND v(vout) AT=19u
  meas tran vo_droop  MIN  v(vout) FROM=20u TO=30u
  meas tran vo_over   MAX  v(vout) FROM=40u TO=50u
  meas tran vo_settle FIND v(vout) AT=39u
  * Write the waveform. The droop and the release overshoot are this block's two headline
  * misses and both are shapes, not scalars -- 338 mV of droop says nothing about how long
  * the output is out of regulation, and "to the 3.3 V rail" says nothing about how sharp
  * the excursion is. A reader scoping the block needs to see them.
  wrdata step.csv v(vout)

  * Droop and overshoot against STEP SIZE. The 120 mV target these are judged against came
  * from our own proposal, not from a requirement -- the 2026-09-01 review confirmed the
  * load step and its droop are OURS TO SPECIFY. A specification written from one step size
  * is a guess; this sweeps four so the promise can be "up to N mA" with a number behind it.
  * Same .meas definitions and the same windows as the 1 -> 20 mA case above.
  alter @Iload[pulse] = [ 1m 2m 20u 1u 1u 20u 60u ]
  tran 20n 60u
  meas tran vp_02 FIND v(vout) AT=19u
  meas tran vd_02 MIN  v(vout) FROM=20u TO=30u
  meas tran vo_02 MAX  v(vout) FROM=40u TO=50u
  alter @Iload[pulse] = [ 1m 5m 20u 1u 1u 20u 60u ]
  tran 20n 60u
  meas tran vp_05 FIND v(vout) AT=19u
  meas tran vd_05 MIN  v(vout) FROM=20u TO=30u
  meas tran vo_05 MAX  v(vout) FROM=40u TO=50u
  alter @Iload[pulse] = [ 1m 10m 20u 1u 1u 20u 60u ]
  tran 20n 60u
  meas tran vp_10 FIND v(vout) AT=19u
  meas tran vd_10 MIN  v(vout) FROM=20u TO=30u
  meas tran vo_10 MAX  v(vout) FROM=40u TO=50u
  alter @Iload[pulse] = [ 1m 3m 20u 1u 1u 20u 60u ]
  tran 20n 60u
  meas tran vp_03 FIND v(vout) AT=19u
  meas tran vd_03 MIN  v(vout) FROM=20u TO=30u
  meas tran vo_03 MAX  v(vout) FROM=40u TO=50u
  alter @Iload[pulse] = [ 1m 7m 20u 1u 1u 20u 60u ]
  tran 20n 60u
  meas tran vp_07 FIND v(vout) AT=19u
  meas tran vd_07 MIN  v(vout) FROM=20u TO=30u
  meas tran vo_07 MAX  v(vout) FROM=40u TO=50u

  * ---- DROOP AGAINST LOAD SLEW RATE. The droop is a ramp-tracking error -- the loop follows
  * the load ramp to about three parts in ten thousand and that residue IS the droop -- so it
  * is a function of dI/dt and not of step size. A specification written as "120 mV at a 20 mA
  * step" therefore names no condition the block can be held to; one written as a RATE does.
  * Same 1 -> 20 mA step throughout, only the edge changes.
  alter @Iload[pulse] = [ 1m 20m 20u 1u 1u 20u 60u ]
  tran 20n 60u
  meas tran vdr_19 MIN v(vout) FROM=20u TO=32u
  alter @Iload[pulse] = [ 1m 20m 20u 2u 2u 20u 60u ]
  tran 20n 60u
  meas tran vdr_95 MIN v(vout) FROM=20u TO=34u
  alter @Iload[pulse] = [ 1m 20m 20u 4u 4u 20u 60u ]
  tran 20n 60u
  meas tran vdr_48 MIN v(vout) FROM=20u TO=38u
  alter @Iload[pulse] = [ 1m 20m 20u 6.5u 6.5u 20u 60u ]
  tran 20n 60u
  meas tran vdr_29 MIN v(vout) FROM=20u TO=43u
  alter @Iload[pulse] = [ 1m 20m 20u 10u 10u 20u 60u ]
  tran 20n 60u
  meas tran vdr_19d MIN v(vout) FROM=20u TO=50u
  alter @Iload[pulse] = [ 1m 20m 20u 20u 20u 20u 60u ]
  tran 20n 80u
  meas tran vdr_095 MIN v(vout) FROM=20u TO=60u
.endc
.end
