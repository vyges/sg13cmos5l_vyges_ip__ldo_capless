* tb_ldo_trim -- output voltage across all 32 VTRIM codes.
*
* The ladder is five binary-weighted segments, each shortable by an NMOS switch: closing
* a switch removes its segment from the lower leg, so R2 falls and vout rises. Code 0 is
* the bottom of the range and code 31 the top, monotonic upward by construction.
*
* This is measured rather than assumed because rhigh carries a fixed contact term of
* about 160 ohm per device on top of its 1360 ohm/sq sheet. Binary-weighted SINGLE
* resistors are therefore not exactly binary -- the small segments are proportionally
* more contact than the large ones -- so the step size is expected to vary across the
* code range. How much is the question this answers.
.lib $PDK_ROOT/ihp-sg13cmos5l/libs.tech/ngspice/models/cornerMOShv.lib mos_tt
.lib $PDK_ROOT/ihp-sg13cmos5l/libs.tech/ngspice/models/cornerMOSlv.lib mos_tt
.include $PDK_ROOT/ihp-sg13cmos5l/libs.tech/ngspice/models/cap_cmomf.lib
.lib $PDK_ROOT/ihp-sg13cmos5l/libs.tech/ngspice/models/cornerRES.lib res_typ
* The resistor model's body terminal is the global substrate node `sub!`. Unless it is
* declared global AND tied, it floats inside each subcircuit, the matrix is singular, and
* ngspice quietly abandons its DC strategies and falls back to a transient operating
* point -- which returns numbers that look plausible and are not solutions. Declare and
* tie it in every bench.
* ldo_enable instantiates a standard-cell inverter for the 1.2 V control-bus side.
.include $PDK_ROOT/ihp-sg13cmos5l/libs.ref/sg13cmos5l_stdcell/spice/sg13cmos5l_stdcell.spice
.global sub!
.include ../sim/netlist/ldo_capless.spice

Vin    vin     0 3.3
Vrefbg vref_bg 0 1.2
Vss    vss     0 0
Vsub sub! 0 0
Ibias  0       ibias DC 1u   $ harness supplies 1 uA (ibias1u_*); multiplied 10x on-slot
Iload  vout    0 DC 1m
Vt0 vtrim0 0 0
Vt1 vtrim1 0 0
Vt2 vtrim2 0 0
Vt3 vtrim3 0 0
Vt4 vtrim4 0 0

* Each code`s output is bound to a NAMED value rather than printed anonymously. A bare
* `print v(vout)` gives the reporting script nothing it can require, so this bench once
* read as a pass from a container that had no ngspice on its PATH at all.
.control
  alter Vt0 dc = 0
  alter Vt1 dc = 0
  alter Vt2 dc = 0
  alter Vt3 dc = 0
  alter Vt4 dc = 0
  op
  echo "CODE 00"
  let vt_00 = v(vout)
  print vt_00
  alter Vt0 dc = 1.2
  alter Vt1 dc = 0
  alter Vt2 dc = 0
  alter Vt3 dc = 0
  alter Vt4 dc = 0
  op
  echo "CODE 01"
  let vt_01 = v(vout)
  print vt_01
  alter Vt0 dc = 0
  alter Vt1 dc = 1.2
  alter Vt2 dc = 0
  alter Vt3 dc = 0
  alter Vt4 dc = 0
  op
  echo "CODE 02"
  let vt_02 = v(vout)
  print vt_02
  alter Vt0 dc = 1.2
  alter Vt1 dc = 1.2
  alter Vt2 dc = 0
  alter Vt3 dc = 0
  alter Vt4 dc = 0
  op
  echo "CODE 03"
  let vt_03 = v(vout)
  print vt_03
  alter Vt0 dc = 0
  alter Vt1 dc = 0
  alter Vt2 dc = 1.2
  alter Vt3 dc = 0
  alter Vt4 dc = 0
  op
  echo "CODE 04"
  let vt_04 = v(vout)
  print vt_04
  alter Vt0 dc = 1.2
  alter Vt1 dc = 0
  alter Vt2 dc = 1.2
  alter Vt3 dc = 0
  alter Vt4 dc = 0
  op
  echo "CODE 05"
  let vt_05 = v(vout)
  print vt_05
  alter Vt0 dc = 0
  alter Vt1 dc = 1.2
  alter Vt2 dc = 1.2
  alter Vt3 dc = 0
  alter Vt4 dc = 0
  op
  echo "CODE 06"
  let vt_06 = v(vout)
  print vt_06
  alter Vt0 dc = 1.2
  alter Vt1 dc = 1.2
  alter Vt2 dc = 1.2
  alter Vt3 dc = 0
  alter Vt4 dc = 0
  op
  echo "CODE 07"
  let vt_07 = v(vout)
  print vt_07
  alter Vt0 dc = 0
  alter Vt1 dc = 0
  alter Vt2 dc = 0
  alter Vt3 dc = 1.2
  alter Vt4 dc = 0
  op
  echo "CODE 08"
  let vt_08 = v(vout)
  print vt_08
  alter Vt0 dc = 1.2
  alter Vt1 dc = 0
  alter Vt2 dc = 0
  alter Vt3 dc = 1.2
  alter Vt4 dc = 0
  op
  echo "CODE 09"
  let vt_09 = v(vout)
  print vt_09
  alter Vt0 dc = 0
  alter Vt1 dc = 1.2
  alter Vt2 dc = 0
  alter Vt3 dc = 1.2
  alter Vt4 dc = 0
  op
  echo "CODE 10"
  let vt_10 = v(vout)
  print vt_10
  alter Vt0 dc = 1.2
  alter Vt1 dc = 1.2
  alter Vt2 dc = 0
  alter Vt3 dc = 1.2
  alter Vt4 dc = 0
  op
  echo "CODE 11"
  let vt_11 = v(vout)
  print vt_11
  alter Vt0 dc = 0
  alter Vt1 dc = 0
  alter Vt2 dc = 1.2
  alter Vt3 dc = 1.2
  alter Vt4 dc = 0
  op
  echo "CODE 12"
  let vt_12 = v(vout)
  print vt_12
  alter Vt0 dc = 1.2
  alter Vt1 dc = 0
  alter Vt2 dc = 1.2
  alter Vt3 dc = 1.2
  alter Vt4 dc = 0
  op
  echo "CODE 13"
  let vt_13 = v(vout)
  print vt_13
  alter Vt0 dc = 0
  alter Vt1 dc = 1.2
  alter Vt2 dc = 1.2
  alter Vt3 dc = 1.2
  alter Vt4 dc = 0
  op
  echo "CODE 14"
  let vt_14 = v(vout)
  print vt_14
  alter Vt0 dc = 1.2
  alter Vt1 dc = 1.2
  alter Vt2 dc = 1.2
  alter Vt3 dc = 1.2
  alter Vt4 dc = 0
  op
  echo "CODE 15"
  let vt_15 = v(vout)
  print vt_15
  alter Vt0 dc = 0
  alter Vt1 dc = 0
  alter Vt2 dc = 0
  alter Vt3 dc = 0
  alter Vt4 dc = 1.2
  op
  echo "CODE 16"
  let vt_16 = v(vout)
  print vt_16
  alter Vt0 dc = 1.2
  alter Vt1 dc = 0
  alter Vt2 dc = 0
  alter Vt3 dc = 0
  alter Vt4 dc = 1.2
  op
  echo "CODE 17"
  let vt_17 = v(vout)
  print vt_17
  alter Vt0 dc = 0
  alter Vt1 dc = 1.2
  alter Vt2 dc = 0
  alter Vt3 dc = 0
  alter Vt4 dc = 1.2
  op
  echo "CODE 18"
  let vt_18 = v(vout)
  print vt_18
  alter Vt0 dc = 1.2
  alter Vt1 dc = 1.2
  alter Vt2 dc = 0
  alter Vt3 dc = 0
  alter Vt4 dc = 1.2
  op
  echo "CODE 19"
  let vt_19 = v(vout)
  print vt_19
  alter Vt0 dc = 0
  alter Vt1 dc = 0
  alter Vt2 dc = 1.2
  alter Vt3 dc = 0
  alter Vt4 dc = 1.2
  op
  echo "CODE 20"
  let vt_20 = v(vout)
  print vt_20
  alter Vt0 dc = 1.2
  alter Vt1 dc = 0
  alter Vt2 dc = 1.2
  alter Vt3 dc = 0
  alter Vt4 dc = 1.2
  op
  echo "CODE 21"
  let vt_21 = v(vout)
  print vt_21
  alter Vt0 dc = 0
  alter Vt1 dc = 1.2
  alter Vt2 dc = 1.2
  alter Vt3 dc = 0
  alter Vt4 dc = 1.2
  op
  echo "CODE 22"
  let vt_22 = v(vout)
  print vt_22
  alter Vt0 dc = 1.2
  alter Vt1 dc = 1.2
  alter Vt2 dc = 1.2
  alter Vt3 dc = 0
  alter Vt4 dc = 1.2
  op
  echo "CODE 23"
  let vt_23 = v(vout)
  print vt_23
  alter Vt0 dc = 0
  alter Vt1 dc = 0
  alter Vt2 dc = 0
  alter Vt3 dc = 1.2
  alter Vt4 dc = 1.2
  op
  echo "CODE 24"
  let vt_24 = v(vout)
  print vt_24
  alter Vt0 dc = 1.2
  alter Vt1 dc = 0
  alter Vt2 dc = 0
  alter Vt3 dc = 1.2
  alter Vt4 dc = 1.2
  op
  echo "CODE 25"
  let vt_25 = v(vout)
  print vt_25
  alter Vt0 dc = 0
  alter Vt1 dc = 1.2
  alter Vt2 dc = 0
  alter Vt3 dc = 1.2
  alter Vt4 dc = 1.2
  op
  echo "CODE 26"
  let vt_26 = v(vout)
  print vt_26
  alter Vt0 dc = 1.2
  alter Vt1 dc = 1.2
  alter Vt2 dc = 0
  alter Vt3 dc = 1.2
  alter Vt4 dc = 1.2
  op
  echo "CODE 27"
  let vt_27 = v(vout)
  print vt_27
  alter Vt0 dc = 0
  alter Vt1 dc = 0
  alter Vt2 dc = 1.2
  alter Vt3 dc = 1.2
  alter Vt4 dc = 1.2
  op
  echo "CODE 28"
  let vt_28 = v(vout)
  print vt_28
  alter Vt0 dc = 1.2
  alter Vt1 dc = 0
  alter Vt2 dc = 1.2
  alter Vt3 dc = 1.2
  alter Vt4 dc = 1.2
  op
  echo "CODE 29"
  let vt_29 = v(vout)
  print vt_29
  alter Vt0 dc = 0
  alter Vt1 dc = 1.2
  alter Vt2 dc = 1.2
  alter Vt3 dc = 1.2
  alter Vt4 dc = 1.2
  op
  echo "CODE 30"
  let vt_30 = v(vout)
  print vt_30
  alter Vt0 dc = 1.2
  alter Vt1 dc = 1.2
  alter Vt2 dc = 1.2
  alter Vt3 dc = 1.2
  alter Vt4 dc = 1.2
  op
  echo "CODE 31"
  let vt_31 = v(vout)
  print vt_31
.endc
.end
