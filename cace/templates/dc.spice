* CACE template from sim/tb_ldo_dc.spice -- DC operating point, line and load regulation
* at the mid trim code. The .meas definitions are copied from that bench unchanged, so
* this datasheet and chipalooza/tools/report.py cannot report different numbers for the
* same specification.
.lib CACE{PDK_ROOT}/ihp-sg13cmos5l/libs.tech/ngspice/models/cornerMOShv.lib CACE{mos_corner}
.lib CACE{PDK_ROOT}/ihp-sg13cmos5l/libs.tech/ngspice/models/cornerMOSlv.lib CACE{mos_corner}
.include CACE{PDK_ROOT}/ihp-sg13cmos5l/libs.tech/ngspice/models/cap_cmomf.lib
.lib CACE{PDK_ROOT}/ihp-sg13cmos5l/libs.tech/ngspice/models/cornerRES.lib CACE{res_corner}
* The resistor model body terminal is the global substrate node sub!. Unless it is
* declared global AND tied it floats, the matrix is singular, and ngspice falls back to a
* transient operating point -- numbers that look plausible and are not solutions.
.include CACE{PDK_ROOT}/ihp-sg13cmos5l/libs.ref/sg13cmos5l_stdcell/spice/sg13cmos5l_stdcell.spice
.global sub!
.include "CACE{DUT_path}"
.temp CACE{temperature}

Vin     vin     0 CACE{vin}
Vrefbg  vref_bg 0 1.2
Vss     vss     0 0
Vddd    vddd    0 1.2
Ven     en      0 1.2
Vilim   ilim_en 0 1.2
Vsub    sub!    0 0
Ibias   0       ibias DC 1u
Iload   vout    0 DC 1m

* mid code (10000b = 16): only the MSB segment shorted
Vt0 vtrim0 0 0
Vt1 vtrim1 0 0
Vt2 vtrim2 0 0
Vt3 vtrim3 0 0
Vt4 vtrim4 0 1.2

* CACE marks the DUT symbol primitive and netlists the top level as a REAL .subckt, where
* sim/run.sh leaves it commented and flat -- so the DUT is instantiated here. This port
* order is the .subckt line of netlist/schematic/ldo_capless.spice verbatim: the one thing
* in this file that must never be typed from memory.
Xdut vref_bg ibias en ilim_en vtrim0 vtrim1 vtrim2 vtrim3 vtrim4 vout pgood oc vin vddd vss ldo_capless

.control
  * An ngspice vector belongs to the plot of the analysis that created it, so a value
  * computed after the first .dc is unreachable once the second .dc opens a new plot --
  * which silently emitted one column instead of three. Capture each result into a shell
  * variable at the moment it exists; those survive the plot change.
  op
  let v_op = v(vout)
  set s_vout = $&v_op

  dc Vin 2.8 3.6 0.02
  meas dc vo_lo FIND v(vout) AT=2.9
  meas dc vo_hi FIND v(vout) AT=3.58
  * Emit BASE units (V/V, V). CACE applies the prefix in 'unit' itself, so a value
  * pre-scaled to mV is reported 1000x too large and silently fails its limit.
  let lr = abs(vo_hi-vo_lo)/(3.58-2.9)
  set s_linereg = $&lr

  dc Iload 0 50m 2m
  meas dc vo_noload   FIND v(vout) AT=0
  meas dc vo_fullload FIND v(vout) AT=48m
  let ldr = abs(vo_noload-vo_fullload)
  set s_loadreg = $&ldr

  echo "$s_vout $s_linereg $s_loadreg" > CACE{simpath}/CACE{filename}_CACE{N}.data
.endc
.end
